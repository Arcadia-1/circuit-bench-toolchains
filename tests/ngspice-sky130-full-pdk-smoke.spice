Circuit-Bench complete official Sky130 ngspice tree smoke test
* This entry point resolves relative includes across libs.tech and libs.ref.
.lib /opt/sky130/pdk/sky130A/libs.tech/ngspice/sky130.lib.spice tt

VDD vdd 0 1.8
VIN in 0 0
* Sky130 wrapper geometry is expressed as numeric micrometres.
X1 out in 0 0 sky130_fd_pr__nfet_01v8 L=0.15 W=1
X2 out in vdd vdd sky130_fd_pr__pfet_01v8 L=0.15 W=2

.op
.end
