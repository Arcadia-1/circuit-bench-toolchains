* Local hierarchy ending in an official SKY130 wrapper and allowed R/C.
.subckt leaf d g s b
XCORE d g s b sky130_fd_pr__nfet_01v8 l=0.15 w=1
RBIAS g s 10k
CLOAD d s 1p
.ends leaf

.subckt dut d g s b
XLEAF d g s b leaf params: scale=1
.ends dut
